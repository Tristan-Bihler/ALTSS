* Spannungsteiler R1=R2=10k, V1=5V DC
* Knoten: in=Eingang, out=Ausgang (Mitte), 0=GND
V1 in 0 DC 5
R1 in out 10k
R2 out 0 10k
.op
.backanno
.end
